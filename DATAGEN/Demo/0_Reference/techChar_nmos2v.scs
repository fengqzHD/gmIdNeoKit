// Design: mosChar/techChar_nmos2v
simulator lang=spectre
global 0
parameters ds=0.9 gs=0.9 sb=0
include "/tech/tsmc/tsmc180/tsmc180_rhuq_MEA/tsmc180/models/spectre/cmn018_assp_v1d3.scs" section=tt

// mosChar/techChar_nmos2v/schematic
MN (vdn vgn vx vbn) nch l=180.0n w=10u m=1 nf=2
VNOI (vx 0) vsource dc=0 type=dc
VBSN (vbn 0) vsource dc=-sb type=dc
VDSN (vdn 0) vsource dc=ds type=dc
VGSN (vgn 0) vsource dc=gs type=dc
simulatorOptions options temp=27
dcOp dc
dc dc param=gs start=0 stop=1.8 step=10m
